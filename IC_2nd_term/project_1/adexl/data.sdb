ADE simulation setup
Run mode: Single Run, Sweeps and Corners
Tests:
  IC_2nd_term:project_1:1: IC_2nd_term/project_1/schematic, simulator spectre
    Outputs: LPF AC; HPF AC; BSF AC; BPF AC
